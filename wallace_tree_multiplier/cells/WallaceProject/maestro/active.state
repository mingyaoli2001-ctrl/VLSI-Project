ADE simulation setup
Test tutorial_WallaceProject_1: tutorial/WallaceProject/schematic, simulator spectre
  Models: /package/eda/cadence/gpdk045/gpdk045_v_6_0/gpdk045/../models/spectre/gpdk045.scs[mc]
  Temperature: 27
  Files: vectors /home/ecegridfs/a/559mg81/wallace/in_vector.vec
  Stimulus vdd: voltage dc dc=1 srcType=dc
  Stimulus gnd: voltage dc dc=0 srcType=dc
  Analysis tran: stop=200n
  Signals: /a<0:7>, /b<0:7>, /s<0>, /s<1>, /s<2>, /s<3>, /s<4>, /s<5>, /s<6>, /s<7>, /s<8>, /s<9>, /s<10>, /s<11>, /s<12>, /s<13>, /s<14>, /s<15>
