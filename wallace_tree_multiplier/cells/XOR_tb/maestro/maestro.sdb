ADE simulation setup
Run mode: Single Run, Sweeps and Corners
Tests:
  tutorial_XOR_tb_1: tutorial/XOR_tb/schematic, simulator spectre
