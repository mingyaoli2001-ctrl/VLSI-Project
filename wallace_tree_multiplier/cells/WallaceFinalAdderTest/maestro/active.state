ADE simulation setup
Test tutorial_WallaceFinalAdderTest_1: tutorial/WallaceFinalAdderTest/config, simulator spectre
  Models: /package/eda/cadence/gpdk045/gpdk045_v_6_0/gpdk045/../models/spectre/gpdk045.scs[tt]
  Temperature: 27
  Stimulus vdd!: voltage dc dc=1 srcType=dc
  Stimulus aout<5>: voltage bit val1=1 val0=0 rise=50p fall=50p period=500p srcType=bit data=001111
  Stimulus aout<6>: voltage bit val1=1 val0=0 rise=50p fall=50p period=500p srcType=bit data=000000
  Stimulus aout<7>: voltage bit val1=1 val0=0 rise=50p fall=50p period=500p srcType=bit data=000000
  Stimulus aout<8>: voltage bit val1=1 val0=0 rise=50p fall=50p period=500p srcType=bit data=000000
  Stimulus aout<9>: voltage bit val1=1 val0=0 rise=50p fall=50p period=500p srcType=bit data=001111
  Stimulus aout<10>: voltage bit val1=1 val0=0 rise=50p fall=50p period=500p srcType=bit data=000000
  Stimulus aout<11>: voltage bit val1=1 val0=0 rise=50p fall=50p period=500p srcType=bit data=000000
  Stimulus aout<12>: voltage bit val1=1 val0=0 rise=50p fall=50p period=500p srcType=bit data=000000
  Stimulus aout<13>: voltage bit val1=1 val0=0 rise=50p fall=50p period=500p srcType=bit data=000000
  Stimulus aout<14>: voltage bit val1=1 val0=0 rise=50p fall=50p period=500p srcType=bit data=000000
  Stimulus bout<5>: voltage bit val1=1 val0=0 rise=50p fall=50p period=500p srcType=bit data=000000
  Stimulus bout<6>: voltage bit val1=1 val0=0 rise=50p fall=50p period=500p srcType=bit data=000000
  Stimulus bout<7>: voltage bit val1=1 val0=0 rise=50p fall=50p period=500p srcType=bit data=000000
  Stimulus bout<8>: voltage bit val1=1 val0=0 rise=50p fall=50p period=500p srcType=bit data=000000
  Stimulus bout<9>: voltage bit val1=1 val0=0 rise=50p fall=50p period=500p srcType=bit data=000000
  Stimulus bout<10>: voltage bit val1=1 val0=0 rise=50p fall=50p period=500p srcType=bit data=001111
  Stimulus bout<11>: voltage bit val1=1 val0=0 rise=50p fall=50p period=500p srcType=bit data=000000
  Stimulus bout<12>: voltage bit val1=1 val0=0 rise=50p fall=50p period=500p srcType=bit data=000000
  Stimulus bout<13>: voltage bit val1=1 val0=0 rise=50p fall=50p period=500p srcType=bit data=000000
  Stimulus bout<14>: voltage bit val1=1 val0=0 rise=50p fall=50p period=500p srcType=bit data=000000
  Analysis tran: stop=10n
  Signals: /s<5:14>, /aout<5:14>
Run mode: Single Run, Sweeps and Corners
