ADE simulation setup
Run mode: Single Run, Sweeps and Corners
Tests:
  tutorial_WallaceFinalAdderTest_1: tutorial/WallaceFinalAdderTest/config, simulator spectre
