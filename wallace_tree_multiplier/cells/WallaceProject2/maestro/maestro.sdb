ADE simulation setup
Run mode: Single Run, Sweeps and Corners
Tests:
  tutorial_WallaceProject_1: tutorial/WallaceProject/schematic, simulator spectre
