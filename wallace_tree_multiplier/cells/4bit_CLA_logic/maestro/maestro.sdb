ADE simulation setup
Run mode: Single Run, Sweeps and Corners
Tests:
  tutorial_3bit_CLA_logic_1: tutorial/4bit_CLA_logic/schematic, simulator spectre
