ADE simulation setup
Test tutorial_NAND_sim_1: tutorial/NAND_sim/schematic, simulator spectre
  Models: /package/eda/cadence/gpdk045/gpdk045_v_6_0/gpdk045/../models/spectre/gpdk045.scs[tt]
  Temperature: 27
  Stimulus In<0>: voltage dc dc=1.1 srcType=dc
  Stimulus In<1>: voltage pulse val0=0 val1=1.1 period=600p rise=30p fall=30p width=300p srcType=pulse
  Stimulus vdd!: voltage dc dc=1.1 srcType=dc
  Analysis tran: stop=30n
  Output A Fixed at 1, B Rises = delay(?wf1 VT("/In<1>") ?value1 0.55 ?edge1 "rising" ?nth1 1 ?td1 0.0 ?tol1 nil ?wf2 VT("/Out<0>") ?value2 0.55 ?edge2 "falling" ?nth2 1 ?tol2 nil ?td2 nil ?stop nil ?multiple nil)
  Output A Fixed at 1, B Falls = delay(?wf1 VT("/In<1>") ?value1 0.55 ?edge1 "falling" ?nth1 1 ?td1 0.0 ?tol1 nil ?wf2 VT("/Out<0>") ?value2 0.55 ?edge2 "rising" ?nth2 1 ?tol2 nil ?td2 nil ?stop nil ?multiple nil)
  Output B Fixed at 1, A Falls = delay(?wf1 VT("/In<0>") ?value1 0.55 ?edge1 "rising" ?nth1 1 ?td1 0.0 ?tol1 nil ?wf2 VT("/Out<0>") ?value2 0.55 ?edge2 "falling" ?nth2 1 ?tol2 nil ?td2 nil ?stop nil ?multiple nil)
  Output B Fixed at 1, A Rises = delay(?wf1 VT("/In<0>") ?value1 0.55 ?edge1 "falling" ?nth1 1 ?td1 0.0 ?tol1 nil ?wf2 VT("/Out<0>") ?value2 0.55 ?edge2 "rising" ?nth2 1 ?tol2 nil ?td2 nil ?stop nil ?multiple nil)
  Signals: /In<0:1>, /Out<0>
Run mode: Single Run, Sweeps and Corners
