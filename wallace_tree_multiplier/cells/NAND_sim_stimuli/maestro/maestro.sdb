ADE simulation setup
Run mode: Single Run, Sweeps and Corners
Tests:
  tutorial_NAND_sim_1: tutorial/NAND_sim/schematic, simulator spectre
    Outputs: "/Out<0>"; /Out<0>
