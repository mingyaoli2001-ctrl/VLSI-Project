ADE simulation setup
Test tutorial_AND_1: tutorial/AND/schematic, simulator spectre
  Models: /package/eda/cadence/gpdk045/gpdk045_v_6_0/gpdk045/../models/spectre/gpdk045.scs[mc]
  Temperature: 27
  Stimulus a: voltage pulse dc=1 val0=0 val1=1 period=10n srcType=pulse
  Stimulus Vdd: voltage dc dc=1 srcType=dc
  Stimulus b: voltage pulse dc=0 val0=0 val1=1 period=20n srcType=pulse
  Stimulus gnd: voltage dc dc=0 srcType=dc
  Analysis tran: stop=100n
  Signals: /a, /b, /Vout
