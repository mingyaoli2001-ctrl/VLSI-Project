ADE simulation setup
Run mode: Single Run, Sweeps and Corners
Tests:
  tutorial_MAC_1: tutorial/MAC/schematic, simulator spectre
