ADE simulation setup
Run mode: Single Run, Sweeps and Corners
Tests:
  tutorial_WallaceProjectTest_1: tutorial/WallaceProjectTest/config, simulator spectre
    Outputs: Drive 1V; abs(integ((VT("/net1") * IT("/I0/vdd")) 1e-08 1.18e-08 " "))
