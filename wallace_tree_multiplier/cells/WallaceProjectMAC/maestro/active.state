ADE simulation setup
Test tutorial_WallaceProject_1: tutorial/WallaceProject/schematic, simulator spectre
  Models: /package/eda/cadence/gpdk045/gpdk045_v_6_0/gpdk045/../models/spectre/gpdk045.scs[mc]
  Temperature: 27
  Files: vectors /home/ecegridfs/a/559mg81/wallace/in_vector.vec
  Stimulus vdd: voltage dc dc=1 srcType=dc
  Stimulus gnd: voltage dc dc=0 srcType=dc
  Analysis tran: stop=200n
  Output abs(integ((VT("/vdd") * IT("/I23/vdd")) 2e-08 3e-08))
  Output abs(integ((VT("/vdd") * IT("/I23/vdd")) 1e-08 2e-08))
  Output integ((VT("/vdd") * IT("/I23/vdd")) 1e-08 1.1003e-08 " ")
  Output delay(?wf1 VT("/a<3>") ?value1 0.5 ?edge1 "either" ?nth1 1 ?td1 0.0 ?tol1 nil ?wf2 VT("/s<10>") ?value2 0.5 ?edge2 "rising" ?nth2 1 ?tol2 nil ?td2 nil ?stop nil ?multiple nil)
  Output integ((VT("/vdd") * IT("/I23/vdd")) 4e-08 4.1003e-08 " ")
  Signals: /a<0:7>, /b<0:7>, /s<0>, /s<1>, /s<2>, /s<3>, /s<4>, /s<5>, /s<6>, /s<7>, /s<8>, /s<9>, /s<10>, /s<11>, /s<12>, /s<13>, /s<14>, /s<15>, /vdd, /I23/vdd (terminal), /I166/net18, /I166/net3
