ADE simulation setup
Run mode: Single Run, Sweeps and Corners
Tests:
  tutorial_TGtest_1: tutorial/TGtest/schematic, simulator spectre
