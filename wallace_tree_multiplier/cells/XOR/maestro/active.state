ADE simulation setup
Test tutorial_XOR_1: tutorial/XOR/schematic, simulator spectre
  Models: /package/eda/cadence/gpdk045/gpdk045_v_6_0/gpdk045/../models/spectre/gpdk045.scs[mc]
  Temperature: 27
  Stimulus vdd: voltage dc dc=1 srcType=dc
  Stimulus gnd: voltage dc dc=0 srcType=dc
  Stimulus a: voltage bit val1=1 val0=0 rise=30p fall=30p period=300p srcType=bit data=0011
  Stimulus b: voltage bit val1=1 val0=0 rise=30p fall=30p period=300p srcType=bit data=0101
  Analysis tran: stop=3n
  Signals: /a, /b, /f
Run mode: Single Run, Sweeps and Corners
