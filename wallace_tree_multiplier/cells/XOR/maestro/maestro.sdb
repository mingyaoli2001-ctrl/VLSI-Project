ADE simulation setup
Run mode: Single Run, Sweeps and Corners
Tests:
  tutorial_XOR_1: tutorial/XOR/schematic, simulator spectre
