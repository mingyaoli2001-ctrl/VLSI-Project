ADE simulation setup
Test tutorial_InverterTest_1: tutorial/InverterTest/schematic, simulator spectre
  Models: /package/eda/cadence/gpdk045/gpdk045_v_6_0/gpdk045/../models/spectre/gpdk045.scs[tt]
  Temperature: 27
  Stimulus In<0>: voltage bit val1=1.1 val0=0 rise=100p fall=100p period=1n srcType=bit data=10101100 rpttimes=-1
  Stimulus In<1>: voltage pulse val0=0 val1=1.1 period=2n rise=100p fall=100p width=1n srcType=pulse
  Stimulus vdd!: voltage dc dc=1.1 srcType=dc
  Analysis tran: stop=30n
  Signals: /In<0:1>, /Out<0:1>
