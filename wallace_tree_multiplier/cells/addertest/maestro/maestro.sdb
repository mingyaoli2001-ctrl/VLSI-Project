ADE simulation setup
Run mode: Single Run, Sweeps and Corners
Tests:
  tutorial_addertest_1: tutorial/addertest/schematic, simulator spectre
