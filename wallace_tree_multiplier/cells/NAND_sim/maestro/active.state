ADE simulation setup
Test tutorial_NAND_sim_1: tutorial/NAND_sim/schematic, simulator spectre
  Models: /package/eda/cadence/gpdk045/gpdk045_v_6_0/gpdk045/../models/spectre/gpdk045.scs[mc]
  Variables: Lmin = 45n; Wp = 160n
  Temperature: 27
  Analysis tran: stop=3n errpreset=moderate
  Output delay(?wf1 VT("/Va") ?value1 0.5 ?edge1 "falling" ?nth1 1 ?td1 0.0 ?tol1 nil ?wf2 VT("/Vout") ?value2 0.5 ?edge2 "rising" ?nth2 1 ?tol2 nil ?td2 nil ?stop nil ?multiple nil) (unticked)
  Output delay(?wf1 VT("/Va") ?value1 0.5 ?edge1 "rising" ?nth1 1 ?td1 0.0 ?tol1 nil ?wf2 VT("/Vout") ?value2 0.5 ?edge2 "falling" ?nth2 1 ?tol2 nil ?td2 nil ?stop nil ?multiple nil) (unticked)
  Output integ((VT("/net4") * IT("/I0/Vdd")) 0 3e-09 " ")
  Signals: /Vout, /Va, /Vb, /net4, /I0/Vdd (terminal)
Run mode: Single Run, Sweeps and Corners
