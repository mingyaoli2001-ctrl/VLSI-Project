ADE simulation setup
Run mode: Single Run, Sweeps and Corners
Tests:
  tutorial_NAND_sim_1: tutorial/NAND_sim/schematic, simulator spectre
    Variables: Lmin = 45n; Wp = 160n
    Outputs: "/uuu"
