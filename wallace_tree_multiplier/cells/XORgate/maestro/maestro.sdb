ADE simulation setup
Run mode: Single Run, Sweeps and Corners
Tests:
  tutorial_XORgate_1: tutorial/XORgate/physConfig, simulator spectre
