ADE simulation setup
Test tutorial_FAdder_1: tutorial/FAdder/physConfig, simulator spectre
  Models: /package/eda/cadence/gpdk045/gpdk045_v_6_0/gpdk045/../models/spectre/gpdk045.scs[tt]
  Temperature: 27
  Stimulus b: voltage bit val1=1 val0=0 rise=50p fall=50p period=2n srcType=bit data=10101100 rpttimes=-1
  Stimulus cin: voltage dc dc=0 srcType=dc
  Stimulus a: voltage bit val1=1 val0=0 rise=50p fall=50p period=1n srcType=bit data=1010101010 rpttimes=-1
  Stimulus vdd: voltage dc dc=1 srcType=dc
  Stimulus gnd: voltage dc dc=0 srcType=dc
  Analysis tran: stop=50n
  Output delay(?wf1 VT("/a") ?value1 0.5 ?edge1 "rising" ?nth1 1 ?td1 0.0 ?tol1 nil ?wf2 VT("/cout") ?value2 0.5 ?edge2 "rising" ?nth2 1 ?tol2 nil ?td2 nil ?stop nil ?multiple nil)
  Output delay(?wf1 VT("/a") ?value1 0.5 ?edge1 "falling" ?nth1 1 ?td1 0.0 ?tol1 nil ?wf2 VT("/cout") ?value2 0.5 ?edge2 "falling" ?nth2 1 ?tol2 nil ?td2 nil ?stop nil ?multiple nil)
  Signals: /a, /b, /cin, /s, /cout, /p
