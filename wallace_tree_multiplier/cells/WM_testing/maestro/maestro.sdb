ADE simulation setup
Run mode: Single Run, Sweeps and Corners
Tests:
  tutorial_WM_testing_1: tutorial/WM_testing/schematic, simulator spectre
