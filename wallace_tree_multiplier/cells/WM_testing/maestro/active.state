ADE simulation setup
Test tutorial_WM_testing_1: tutorial/WM_testing/schematic, simulator spectre
  Models: /package/eda/cadence/gpdk045/gpdk045_v_6_0/gpdk045/../models/spectre/gpdk045.scs[mc]
  Temperature: 27
  Stimulus b<0>: voltage bit rise=50p fall=50p period=1n srcType=bit data=11111111
  Stimulus b<1>: voltage bit rise=50p fall=50p period=1n srcType=bit data=11111111
  Stimulus b<2>: voltage bit rise=50p fall=50p period=1n srcType=bit data=11111111
  Stimulus b<3>: voltage bit rise=50p fall=50p period=1n srcType=bit data=11111111
  Stimulus b<4>: voltage bit rise=50p fall=50p period=1n srcType=bit data=11111111
  Stimulus b<5>: voltage bit rise=50p fall=50p period=1n srcType=bit data=11111111
  Stimulus b<6>: voltage bit rise=50p fall=50p period=1n srcType=bit data=11111111
  Stimulus b<7>: voltage bit rise=50p fall=50p period=1n srcType=bit data=11111111
  Stimulus gnd: voltage dc dc=0 srcType=dc
  Stimulus vdd: voltage dc dc=1 srcType=dc
  Stimulus a<0>: voltage bit rise=50p fall=50p period=1n srcType=bit data=11111111
  Stimulus a<1>: voltage bit rise=50p fall=50p period=1n srcType=bit data=11111111
  Stimulus a<2>: voltage bit rise=50p fall=50p period=1n srcType=bit data=11111111
  Stimulus a<3>: voltage bit rise=50p fall=50p period=1n srcType=bit data=11111111
  Stimulus a<4>: voltage bit rise=50p fall=50p period=1n srcType=bit data=11111111
  Stimulus a<5>: voltage bit rise=50p fall=50p period=1n srcType=bit data=11111111
  Stimulus a<6>: voltage bit rise=50p fall=50p period=1n srcType=bit data=11111111
  Stimulus a<7>: voltage bit rise=50p fall=50p period=1n srcType=bit data=11111111
  Analysis tran: stop=100n
  Signals: /p<58>, /p<59>, /p<60>, /p<56>, /p<55>, /p<54>, /p<53>, /p<52>, /p<51>, /p<50>, /p<49>, /p<48>, /p<47>, /p<46>, /p<45>, /p<44>, /p<43>, /p<42>, /p<41>, /p<40>, /p<39>, /p<38>, /p<37>, /p<36>, /p<35>, /p<34>, /p<33>, /p<32>, /p<31>, /p<30>, /p<29>, /p<28>, /p<27>, /p<26>, /p<25>, /p<24>, /p<23>, /p<22>, /p<21>, /p<20>, /p<19>, /p<18>, /p<17>, /p<16>, /p<15>, /p<14>, /p<13>, /p<12>, /p<11>, /p<10>, /p<9>, /p<8>, /p<7>, /p<6>, /p<5>, /p<4>, /p<3>, /p<2>, /p<1>, /p<61>, /p<63>, /p<0>, /p<62>, /p<57>, /a<0:7>, /b<0:7>
Run mode: Single Run, Sweeps and Corners
