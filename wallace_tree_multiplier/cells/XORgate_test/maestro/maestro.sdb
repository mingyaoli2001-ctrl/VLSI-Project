ADE simulation setup
Run mode: Single Run, Sweeps and Corners
Tests:
  tutorial_XORgate_test_1: tutorial/XORgate_test/schematic, simulator spectre
    Outputs: A; B; Y
