ADE simulation setup
Test tutorial_inverterv_test_1: tutorial/inverterv_test/schematic, simulator spectre
  Models: /package/eda/cadence/gpdk045/gpdk045_v_6_0/gpdk045/../models/spectre/gpdk045.scs[tt]
  Variables: length = 45n; widthn = 260n; R = 2; widthp = R*widthn
  Temperature: 27
  Analysis tran: stop=3n
  Output tphl = delay(?wf1 VT("/C") ?value1 0.55 ?edge1 "rising" ?nth1 1 ?td1 0.0 ?tol1 nil ?wf2 VT("/B") ?value2 0.55 ?edge2 "falling" ?nth2 1 ?tol2 nil ?td2 nil ?stop nil ?multiple nil)
  Output tplh = delay(?wf1 VT("/B") ?value1 0.55 ?edge1 "falling" ?nth1 1 ?td1 0.0 ?tol1 nil ?wf2 VT("/C") ?value2 0.55 ?edge2 "rising" ?nth2 1 ?tol2 nil ?td2 nil ?stop nil ?multiple nil)
  Signals: /I0/In (terminal), /A, /I1/In (terminal), /B, /I2/In (terminal), /C, /C0/PLUS (terminal), /D
