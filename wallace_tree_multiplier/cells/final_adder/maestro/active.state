ADE simulation setup
Test tutorial_final_adder_1: tutorial/final_adder/schematic, simulator spectre
  Models: /package/eda/cadence/gpdk045/gpdk045_v_6_0/gpdk045/../models/spectre/gpdk045.scs[mc]
  Temperature: 27
  Stimulus VDD: voltage dc dc=1 srcType=dc
  Stimulus GND: voltage dc dc=0 srcType=dc
  Stimulus B<5>: voltage bit val1=1 val0=0 rise=10p fall=10p period=2n srcType=bit data=11111111
  Stimulus B<6>: voltage bit val1=1 val0=0 rise=10p fall=10p period=2n srcType=bit data=00000000
  Stimulus B<7>: voltage bit val1=1 val0=0 rise=10p fall=10p period=2n srcType=bit data=00000000
  Stimulus B<8>: voltage bit val1=1 val0=0 rise=10p fall=10p period=2n srcType=bit data=00000000
  Stimulus B<9>: voltage bit val1=1 val0=0 rise=10p fall=10p period=2n srcType=bit data=11111111
  Stimulus B<10>: voltage bit val1=1 val0=0 rise=10p fall=10p period=2n srcType=bit data=11111111
  Stimulus B<11>: voltage bit val1=1 val0=0 rise=10p fall=10p period=2n srcType=bit data=11111111
  Stimulus B<12>: voltage bit val1=1 val0=0 rise=10p fall=10p period=2n srcType=bit data=00000000
  Stimulus B<13>: voltage bit val1=1 val0=0 rise=10p fall=10p period=2n srcType=bit data=00000000
  Stimulus B<14>: voltage bit val1=1 val0=0 rise=10p fall=10p period=2n srcType=bit data=00000000
  Stimulus A<5>: voltage bit val1=1 val0=0 rise=10p fall=10p period=2n srcType=bit data=11111111
  Stimulus A<6>: voltage bit val1=1 val0=0 rise=10p fall=10p period=2n srcType=bit data=11111111
  Stimulus A<7>: voltage bit val1=1 val0=0 rise=10p fall=10p period=2n srcType=bit data=11111111
  Stimulus A<8>: voltage bit val1=1 val0=0 rise=10p fall=10p period=2n srcType=bit data=11111111
  Stimulus A<9>: voltage bit val1=1 val0=0 rise=10p fall=10p period=2n srcType=bit data=11111111
  Stimulus A<10>: voltage bit val1=1 val0=0 rise=10p fall=10p period=2n srcType=bit data=11111111
  Stimulus A<11>: voltage bit val1=1 val0=0 rise=10p fall=10p period=2n srcType=bit data=11111111
  Stimulus A<12>: voltage bit val1=1 val0=0 rise=10p fall=10p period=2n srcType=bit data=00000000
  Stimulus A<13>: voltage bit val1=1 val0=0 rise=10p fall=10p period=2n srcType=bit data=11111111
  Stimulus A<14>: voltage bit val1=1 val0=0 rise=10p fall=10p period=2n srcType=bit data=11111111
  Analysis tran: stop=100n
  Signals: /A<5:14>, /B<5:14>, /s<5:14>
