ADE simulation setup
Test tutorial_wallacetest_1: tutorial/wallacetest/schematic, simulator spectre
  Models: /package/eda/cadence/gpdk045/gpdk045_v_6_0/gpdk045/../models/spectre/gpdk045.scs[mc]
  Temperature: 27
  Stimulus vdd!: voltage dc dc=1 srcType=dc
  Stimulus a<0>: voltage dc dc=1 srcType=dc
  Stimulus a<1>: voltage dc dc=1 srcType=dc
  Stimulus a<2>: voltage dc dc=1 srcType=dc
  Stimulus a<3>: voltage dc dc=1 srcType=dc
  Stimulus a<4>: voltage dc dc=1 srcType=dc
  Stimulus a<5>: voltage dc dc=1 srcType=dc
  Stimulus a<6>: voltage dc dc=1 srcType=dc
  Stimulus a<7>: voltage dc dc=1 srcType=dc
  Stimulus b<0>: voltage dc dc=1 srcType=dc
  Stimulus b<1>: voltage dc dc=1 srcType=dc
  Stimulus b<2>: voltage bit val1=1 val0=0 rise=50p fall=50p period=1n srcType=bit data=01 rpttimes=-1
  Stimulus b<3>: voltage dc dc=0 srcType=dc
  Stimulus b<4>: voltage dc dc=0 srcType=dc
  Stimulus b<5>: voltage dc dc=0 srcType=dc
  Stimulus b<6>: voltage dc dc=0 srcType=dc
  Stimulus b<7>: voltage dc dc=0 srcType=dc
  Analysis tran: stop=10n
  Output integ((VT("/vdd!") * IT("/I0/vdd")) 1e-09 3e-09 " ")
  Signals: /b<0>, /b<1>, /b<2>, /b<3>, /b<4>, /b<5>, /b<6>, /b<7>, /a<0>, /a<1>, /a<2>, /a<3>, /a<4>, /a<5>, /a<6>, /a<7>, /s<0>, /s<1>, /s<2>, /s<3>, /s<4>, /s<5>, /s<6>, /s<7>, /s<8>, /s<9>, /s<10>, /s<11>, /s<12>, /s<13>, /s<14>, /s<15>, /I0/vdd (terminal)
Run mode: Single Run, Sweeps and Corners
