ADE simulation setup
Run mode: Single Run, Sweeps and Corners
Tests:
  tutorial_wallacetest_1: tutorial/wallacetest/schematic, simulator spectre
