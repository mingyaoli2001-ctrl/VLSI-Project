ADE simulation setup
Test tutorial_DiverTest_1: tutorial/DiverTest/schematic, simulator spectre
  Models: /package/eda/cadence/gpdk045/gpdk045_v_6_0/gpdk045/../models/spectre/gpdk045.scs[tt]
  Temperature: 27
  Analysis tran: stop=50n
  Signals: /a, /b, /I0/a (terminal), /I0/b (terminal), /I0/vdd (terminal), /I0/gnd (terminal)
