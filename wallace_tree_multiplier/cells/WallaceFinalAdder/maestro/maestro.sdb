ADE simulation setup
Run mode: Single Run, Sweeps and Corners
Tests:
  tutorial_WallaceFinalAdder_1: tutorial/WallaceFinalAdder/schematic, simulator spectre
