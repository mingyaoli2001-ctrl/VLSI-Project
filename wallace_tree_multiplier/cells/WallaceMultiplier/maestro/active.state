ADE simulation setup
Test tutorial_WallaceMultiplier_1: tutorial/WallaceMultiplier/schematic, simulator spectre
  Models: /package/eda/cadence/gpdk045/gpdk045_v_6_0/gpdk045/../models/spectre/gpdk045.scs[mc]
  Temperature: 27
  Stimulus a<0>: voltage bit val1=1 val0=0 rise=50p fall=50p period=1n srcType=bit data=10101010 rpttimes=-1
  Stimulus a<1>: voltage bit val1=1 val0=0 rise=50p fall=50p period=1n srcType=bit data=11001100 rpttimes=-1
  Stimulus a<2>: voltage bit val1=1 val0=0 rise=50p fall=50p period=1n srcType=bit data=00001111 rpttimes=-1
  Stimulus a<3>: voltage bit val1=1 val0=0 rise=50p fall=50p period=1n srcType=bit data=11001100 rpttimes=-1
  Stimulus a<4>: voltage bit val1=1 val0=0 rise=50p fall=50p period=1n srcType=bit data=10101010 rpttimes=-1
  Stimulus a<5>: voltage bit val1=1 val0=0 rise=50p fall=50p period=1n srcType=bit data=11001100 rpttimes=-1
  Stimulus a<6>: voltage bit val1=1 val0=0 rise=50p fall=50p period=1n srcType=bit data=00001111 rpttimes=-1
  Stimulus a<7>: voltage bit val1=1 val0=0 rise=50p fall=50p period=1n srcType=bit data=10101010 rpttimes=-1
  Stimulus vdd: voltage dc dc=1 srcType=dc
  Stimulus gnd: voltage dc dc=0 srcType=dc
  Stimulus b<0>: voltage bit val1=1 val0=0 rise=50p fall=50p period=1n srcType=bit data=10101010 rpttimes=-1
  Stimulus b<1>: voltage bit val1=1 val0=0 rise=50p fall=50p period=1n srcType=bit data=00001111 rpttimes=-1
  Stimulus b<2>: voltage bit val1=1 val0=0 rise=50p fall=50p period=1n srcType=bit data=11001100 rpttimes=-1
  Stimulus b<3>: voltage bit val1=1 val0=0 rise=50p fall=50p period=1n srcType=bit data=10101010 rpttimes=-1
  Stimulus b<4>: voltage bit val1=1 val0=0 rise=50p fall=50p period=1n srcType=bit data=11001100 rpttimes=-1
  Stimulus b<5>: voltage bit val1=1 val0=0 rise=50p fall=50p period=1n srcType=bit data=00001111 rpttimes=-1
  Stimulus b<6>: voltage bit val1=1 val0=0 rise=50p fall=50p period=1n srcType=bit data=10101010 rpttimes=-1
  Stimulus b<7>: voltage bit val1=1 val0=0 rise=50p fall=50p period=1n srcType=bit data=10101010 rpttimes=-1
  Analysis tran: stop=20n
  Signals: /p00, /p01, /p02, /p03, /p04, /p05, /p06, /p07, /p10, /p11, /p12, /p13, /p14, /p15, /p16, /p17, /p20, /p21, /p22, /p23, /p24, /p25, /p26, /p27, /p30, /p31, /p32, /p33, /p34, /p35, /p36, /p37, /p40, /p41, /p42, /p43, /p44, /p45, /p46, /p47, /p50, /p51, /p52, /p53, /p54, /p55, /p56, /p57, /p60, /p61, /p62, /p63, /p64, /p65, /p66, /p67, /p70, /p71, /p72, /p73, /p74, /p75, /p76, /p77, /a<0:7>, /b<0:7>
