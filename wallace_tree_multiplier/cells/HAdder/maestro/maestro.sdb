ADE simulation setup
Run mode: Single Run, Sweeps and Corners
Tests:
  tutorial_HAdder_1: tutorial/HAdder/schematic, simulator spectre
