ADE simulation setup
Test tutorial_HAdder_1: tutorial/HAdder/schematic, simulator spectre
  Models: /package/eda/cadence/gpdk045/gpdk045_v_6_0/gpdk045/../models/spectre/gpdk045.scs[mc]
  Temperature: 27
  Stimulus a: voltage bit val1=1 val0=0 rise=50p fall=50p period=2n srcType=bit data=10101100 rpttimes=-1
  Stimulus b: voltage bit val1=1 val0=0 rise=50p fall=50p period=2n srcType=bit data=11001100 rpttimes=-1
  Stimulus vdd: voltage dc dc=1 srcType=dc
  Stimulus gnd: voltage dc dc=0 srcType=dc
  Analysis tran: stop=50n
  Signals: /a, /b, /sum, /carry
Run mode: Single Run, Sweeps and Corners
