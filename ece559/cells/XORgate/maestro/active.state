ADE simulation setup
Test tutorial_XORgate_1: tutorial/XORgate/physConfig, simulator spectre
  Models: /package/eda/cadence/gpdk045/gpdk045_v_6_0/gpdk045/../models/spectre/gpdk045.scs[tt]
  Temperature: 27
  Stimulus a: voltage bit val1=1.1 val0=0 rise=100p fall=100p period=1n srcType=bit data=10101100 rpttimes=-1
  Stimulus b: voltage bit val1=1.1 val0=0 rise=100p fall=100p period=1n srcType=bit data=11111010 rpttimes=-1
  Stimulus vdd: voltage dc dc=1.1 srcType=dc
  Stimulus gnd: voltage dc dc=0 srcType=dc
  Analysis tran: stop=30n
