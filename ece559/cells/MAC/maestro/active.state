ADE simulation setup
Test tutorial_MAC_1: tutorial/MAC/schematic, simulator spectre
  Models: /package/eda/cadence/gpdk045/gpdk045_v_6_0/gpdk045/../models/spectre/gpdk045.scs[mc]
  Temperature: 27
  Files: vectors /home/ecegridfs/a/559mg81/wallace/input_mac.vec
  Stimulus vdd: voltage dc dc=1 srcType=dc
  Stimulus gnd: voltage dc dc=0 srcType=dc
  Analysis tran: stop=30n
  Signals: /s<0:15>, /c<0:15>, /mac<0:16>, /vdd, /gnd
