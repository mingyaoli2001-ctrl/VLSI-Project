ADE simulation setup
Test tutorial_XORgate_test_1: tutorial/XORgate_test/schematic, simulator spectre
  Models: /package/eda/cadence/gpdk045/gpdk045_v_6_0/gpdk045/../models/spectre/gpdk045.scs[tt]
  Temperature: 27
  Stimulus b: voltage pulse val0=0 val1=1 period=20n rise=30.0p fall=30.0p width=10n srcType=pulse
  Stimulus a: voltage pulse val0=0 val1=1 period=10n rise=30.0p fall=30.0p width=5n srcType=pulse
  Stimulus vdd!: voltage dc dc=1 srcType=dc
  Analysis tran: stop=100n
  Signals: /a as A, /b as B, /y as Y
