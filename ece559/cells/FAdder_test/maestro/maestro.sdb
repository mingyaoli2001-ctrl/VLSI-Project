ADE simulation setup
Run mode: Single Run, Sweeps and Corners
Tests:
  tutorial_FAdder_test_1: tutorial/FAdder_test/schematic, simulator spectre
