ADE simulation setup
Test tutorial_WallaceProjectTest_1: tutorial/WallaceProjectTest/config, simulator spectre
  Models: /package/eda/cadence/gpdk045/gpdk045_v_6_0/gpdk045/../models/spectre/gpdk045.scs[tt]
  Temperature: 27
  Files: vectors /home/ecegridfs/a/559mg81/wallace/in_vector.vec
  Stimulus gnd: voltage dc dc=0 srcType=dc
  Analysis tran: stop=100n
  Output Drive 1V = delay(?wf1 VT("/a<3>") ?value1 0.5 ?edge1 "either" ?nth1 1 ?td1 0.0 ?tol1 nil ?wf2 VT("/s<10>") ?value2 0.5 ?edge2 "rising" ?nth2 1 ?tol2 nil ?td2 nil ?stop nil ?multiple nil)
  Output abs(integ((VT("/net1") * IT("/I0/vdd")) 1e-08 1.18e-08 " "))
  Output Drive 1.3V = delay(?wf1 VT("/a<3>") ?value1 0.65 ?edge1 "either" ?nth1 1 ?td1 0.0 ?tol1 nil ?wf2 VT("/s<10>") ?value2 0.65 ?edge2 "rising" ?nth2 1 ?tol2 nil ?td2 nil ?stop nil ?multiple nil)
  Output integ((VT("/net1") * IT("/I0/vdd")) 1e-08 1.18e-08 " ")
  Signals: /a<0:7>, /b<0:7>, /s<0>, /s<1>, /s<2>, /s<3>, /s<4>, /s<5>, /s<6>, /s<7>, /s<8>, /s<9>, /s<10>, /s<11>, /s<12>, /s<13>, /s<14>, /s<15>, /I0/vdd (terminal), /net1, /I0/aout<5:14>, /I0/bout<5:14>
