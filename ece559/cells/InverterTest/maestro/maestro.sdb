ADE simulation setup
Run mode: Single Run, Sweeps and Corners
Tests:
  tutorial_InverterTest_1: tutorial/InverterTest/schematic, simulator spectre
