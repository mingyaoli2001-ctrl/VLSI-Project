ADE simulation setup
Test tutorial_HAdderTest_1: tutorial/HAdderTest/config, simulator spectre
  Models: /package/eda/cadence/gpdk045/gpdk045_v_6_0/gpdk045/../models/spectre/gpdk045.scs[tt]
  Temperature: 27
  Stimulus vdd!: voltage dc dc=1 srcType=dc
  Stimulus a: voltage bit val1=1 val0=0 rise=50p fall=50p period=1n srcType=bit data=10101010 rpttimes=-1
  Stimulus b: voltage bit val1=1 val0=0 rise=50p fall=50p period=2n srcType=bit data=10101010 rpttimes=-1
  Stimulus cin: voltage bit val1=1 val0=0 rise=50p fall=50p period=4n srcType=bit data=1100 rpttimes=-1
  Analysis tran: stop=30n
  Output delay(?wf1 VT("/a") ?value1 0.5 ?edge1 "either" ?nth1 1 ?td1 0.0 ?tol1 nil ?wf2 VT("/s") ?value2 0.5 ?edge2 "rising" ?nth2 1 ?tol2 nil ?td2 nil ?stop nil ?multiple nil)
  Output delay(?wf1 VT("/cout") ?value1 0.5 ?edge1 "either" ?nth1 1 ?td1 0.0 ?tol1 nil ?wf2 VT("/a") ?value2 0.5 ?edge2 "rising" ?nth2 1 ?tol2 nil ?td2 nil ?stop nil ?multiple nil)
  Signals: /a, /b, /cin, /s, /cout
Run mode: Single Run, Sweeps and Corners
