ADE simulation setup
Run mode: Single Run, Sweeps and Corners
Tests:
  tutorial_HAdderTest_1: tutorial/HAdderTest/config, simulator spectre
