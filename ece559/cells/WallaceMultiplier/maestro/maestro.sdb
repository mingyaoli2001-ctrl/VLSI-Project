ADE simulation setup
Run mode: Single Run, Sweeps and Corners
Tests:
  tutorial_WallaceMultiplier_1: tutorial/WallaceMultiplier/schematic, simulator spectre
