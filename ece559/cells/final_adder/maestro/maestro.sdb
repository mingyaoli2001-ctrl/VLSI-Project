ADE simulation setup
Run mode: Single Run, Sweeps and Corners
Tests:
  tutorial_final_adder_1: tutorial/final_adder/schematic, simulator spectre
