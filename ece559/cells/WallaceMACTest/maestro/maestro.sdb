ADE simulation setup
Run mode: Single Run, Sweeps and Corners
Tests:
  tutorial_WallaceMACTest_1: tutorial/WallaceMACTest/config, simulator spectre
