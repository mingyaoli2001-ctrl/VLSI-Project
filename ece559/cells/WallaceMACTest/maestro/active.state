ADE simulation setup
Test tutorial_WallaceMACTest_1: tutorial/WallaceMACTest/config, simulator spectre
  Models: /package/eda/cadence/gpdk045/gpdk045_v_6_0/gpdk045/../models/spectre/gpdk045.scs[mc]
  Temperature: 27
  Stimulus gnd: voltage dc dc=0 srcType=dc
  Stimulus b<0>: voltage dc dc=0 srcType=dc
  Stimulus b<1>: voltage dc dc=0 srcType=dc
  Stimulus b<2>: voltage dc dc=0 srcType=dc
  Stimulus b<3>: voltage bit val1=1.3 val0=0 rise=50p fall=50p period=10n srcType=bit data=01 rpttimes=-1
  Stimulus b<4>: voltage bit val1=1.3 val0=0 rise=50p fall=50p period=10n srcType=bit data=01 rpttimes=-1
  Stimulus b<5>: voltage bit val1=1.3 val0=0 rise=50p fall=50p period=10n srcType=bit data=01 rpttimes=-1
  Stimulus b<6>: voltage dc dc=0 srcType=dc
  Stimulus b<7>: voltage dc dc=0 srcType=dc
  Stimulus a<0>: voltage dc dc=0 srcType=dc
  Stimulus a<1>: voltage dc dc=0 srcType=dc
  Stimulus a<2>: voltage bit val1=1.3 val0=0 rise=50p fall=50p period=10n srcType=bit data=01 rpttimes=-1
  Stimulus a<3>: voltage bit val1=1.3 val0=0 rise=50p fall=50p period=10n srcType=bit data=01 rpttimes=-1
  Stimulus a<4>: voltage bit val1=1.3 val0=0 rise=50p fall=50p period=10n srcType=bit data=01 rpttimes=-1
  Stimulus a<5>: voltage dc dc=0 srcType=dc
  Stimulus a<6>: voltage dc dc=0 srcType=dc
  Stimulus a<7>: voltage dc dc=0 srcType=dc
  Stimulus c<15>: voltage bit val1=1.3 val0=0 rise=50p fall=50p period=10n srcType=bit data=01 rpttimes=-1
  Stimulus c<14>: voltage bit val1=1.3 val0=0 rise=50p fall=50p period=10n srcType=bit data=01 rpttimes=-1
  Stimulus c<13>: voltage bit val1=1.3 val0=0 rise=50p fall=50p period=10n srcType=bit data=01 rpttimes=-1
  Stimulus c<12>: voltage bit val1=1.3 val0=0 rise=50p fall=50p period=10n srcType=bit data=01 rpttimes=-1
  Stimulus c<11>: voltage dc dc=0 srcType=dc
  Stimulus c<10>: voltage dc dc=0 srcType=dc
  Stimulus c<9>: voltage dc dc=0 srcType=dc
  Stimulus c<8>: voltage bit val1=1.3 val0=0 rise=50p fall=50p period=10n srcType=bit data=01 rpttimes=-1
  Stimulus c<7>: voltage bit val1=1.3 val0=0 rise=50p fall=50p period=10n srcType=bit data=01 rpttimes=-1
  Stimulus c<6>: voltage dc dc=0 srcType=dc
  Stimulus c<5>: voltage bit val1=1.3 val0=0 rise=50p fall=50p period=10n srcType=bit data=01 rpttimes=-1
  Stimulus c<4>: voltage dc dc=0 srcType=dc
  Stimulus c<3>: voltage bit val1=1.3 val0=0 rise=50p fall=50p period=10n srcType=bit data=01 rpttimes=-1
  Stimulus c<2>: voltage dc dc=0 srcType=dc
  Stimulus c<1>: voltage bit val1=1.3 val0=0 rise=50p fall=50p period=10n srcType=bit data=01 rpttimes=-1
  Stimulus c<0>: voltage dc dc=0 srcType=dc
  Analysis tran: stop=20n
  Output integ((VT("/net19") * IT("/I0/vdd")) 1e-08 1.41e-08 " ")
  Output delay(?wf1 VT("/a<3>") ?value1 0.5 ?edge1 "either" ?nth1 1 ?td1 0.0 ?tol1 nil ?wf2 VT("/mac<10>") ?value2 0.5 ?edge2 "rising" ?nth2 1 ?tol2 nil ?td2 nil ?stop nil ?multiple nil)
  Signals: /mac<16>, /mac<14>, /mac<15>, /mac<13>, /mac<12>, /mac<11>, /mac<10>, /mac<9>, /mac<8>, /mac<7>, /mac<6>, /mac<5>, /mac<4>, /mac<3>, /mac<2>, /mac<1>, /mac<0>, /s<15>, /s<14>, /s<13>, /s<12>, /s<11>, /s<10>, /s<9>, /s<8>, /s<7>, /s<6>, /s<5>, /s<4>, /s<3>, /s<2>, /s<1>, /s<0>, /c<15>, /c<14>, /c<13>, /c<12>, /c<11>, /c<10>, /c<9>, /c<8>, /c<7>, /c<6>, /c<5>, /c<4>, /c<3>, /c<2>, /c<1>, /c<0>, /a<0:7>, /b<0:7>, /net19, /I0/vdd (terminal)
Run mode: Single Run, Sweeps and Corners
