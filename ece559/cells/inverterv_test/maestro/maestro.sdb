ADE simulation setup
Run mode: Single Run, Sweeps and Corners
Tests:
  tutorial_inverterv_test_1: tutorial/inverterv_test/schematic, simulator spectre
    Variables: length = 45n; widthn = 260n; widthp = R*widthn; R = 2
