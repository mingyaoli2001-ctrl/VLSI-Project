ADE simulation setup
Run mode: Single Run, Sweeps and Corners
Tests:
  tutorial_AND_1: tutorial/AND/schematic, simulator spectre
