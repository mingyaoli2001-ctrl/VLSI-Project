ADE simulation setup
Run mode: Single Run, Sweeps and Corners
Tests:
  tutorial_DiverTest_1: tutorial/DiverTest/schematic, simulator spectre
