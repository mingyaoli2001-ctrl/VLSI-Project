ADE simulation setup
Test tutorial_3bit_CLA_logic_1: tutorial/4bit_CLA_logic/schematic, simulator spectre
  Models: /package/eda/cadence/gpdk045/gpdk045_v_6_0/gpdk045/../models/spectre/gpdk045.scs[mc]
  Temperature: 27
  Stimulus vdd: voltage dc dc=1 srcType=dc
  Stimulus gnd: voltage dc dc=0 srcType=dc
  Stimulus c0: voltage bit val1=1 val0=0 rise=30p fall=30p period=300p srcType=bit data=00001000
  Stimulus p1: voltage bit val1=1 val0=0 rise=30p fall=30p period=300p srcType=bit data=00111111
  Stimulus p2: voltage bit val1=1 val0=0 rise=30p fall=30p period=300p srcType=bit data=00011111
  Stimulus p3: voltage bit val1=1 val0=0 rise=30p fall=30p period=300p srcType=bit data=00001001
  Stimulus g1: voltage bit val1=1 val0=0 rise=30p fall=30p period=300p srcType=bit data=01000011
  Stimulus g2: voltage bit val1=1 val0=0 rise=30p fall=30p period=300p srcType=bit data=00100100
  Stimulus g3: voltage bit val1=1 val0=0 rise=30p fall=30p period=300p srcType=bit data=00010000
  Analysis tran: stop=10n
  Signals: /c0, /p1, /g1, /p2, /g2, /p3, /g3, /cout1, /cout2, /cout3
