ADE simulation setup
Run mode: Single Run, Sweeps and Corners
Tests:
  tutorial_FAdder_1: tutorial/FAdder_test1128/schematic, simulator spectre
    Outputs: delay(?wf1 VT("/cin") ?value1 0.5 ?edge1 "falling" ?nth1 1 ?td1 0.0 ?tol1 nil ?wf2 VT("/cout") ?value2 0.5 ?edge2 "failing" ?nth2 1 ?tol2 nil ?td2 nil ?stop nil ?multiple nil); delay(?wf1 VT("/a") ?value1 0.5 ?edge1 "falling" ?nth1 1 ?td1 0.0 ?tol1 nil ?wf2 VT("/cout") ?value2 0.5 ?edge2 "failling" ?nth2 1 ?tol2 nil ?td2 nil ?stop nil ?multiple nil); delay(?wf1 VT("/a") ?value1 0.5 ?edge1 "falling" ?nth1 1 ?td1 0.0 ?tol1 nil ?wf2 VT("/cout") ?value2 0.5 ?edge2 "falling" ?nth2 1 ?tol2 nil ?td2 nil ?stop nil ?multiple nil)
