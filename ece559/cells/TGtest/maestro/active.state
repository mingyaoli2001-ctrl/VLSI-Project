ADE simulation setup
Test tutorial_TGtest_1: tutorial/TGtest/schematic, simulator spectre
  Models: /package/eda/cadence/gpdk045/gpdk045_v_6_0/gpdk045/../models/spectre/gpdk045.scs[tt]
  Temperature: 27
  Stimulus cin: voltage bit val1=1 val0=0 rise=50p fall=50p period=2n srcType=bit data=1010101010 rpttimes=-1
  Stimulus a: voltage bit val1=1 val0=0 rise=50p fall=50p period=1n srcType=bit data=010101000 rpttimes=-1
  Stimulus vdd: voltage dc dc=1 srcType=dc
  Stimulus gnd: voltage dc dc=0 srcType=dc
  Stimulus b: voltage bit val1=1 val0=0 rise=50p fall=50p period=2n srcType=bit data=101010000 rpttimes=-1
  Analysis tran: stop=20n
  Signals: /a, /b, /cin, /s, /cout
